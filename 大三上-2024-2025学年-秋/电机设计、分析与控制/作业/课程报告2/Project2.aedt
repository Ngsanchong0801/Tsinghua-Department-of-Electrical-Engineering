# Ansys Electronics Desktop project, version 2022.1
materials:
  DW315_50: permeability{HUnit=A_per_meter BUnit=tesla curve (0, 0) (49, 0.4) (52, 0.45) (55, 0.5) (57, 0.55) (61, 0.6) (64, 0.65) (68, 0.7) (73, 0.75) (79, 0.8) (84, 0.85) (95, 0.9) (103, 0.95) (115, 1) (124, 1.05) (142, 1.1) (163, 1.15) (193, 1.2) (235, 1.25) (299, 1.3) (390, 1.35) (518, 1.4) (796, 1.45) (1234, 1.5) (1990, 1.55) (3026, 1.6) (4299, 1.65) (6051, 1.7) (8962, 1.75) (11934, 1.8) (17950, 1.85) (24364, 1.9) (31052, 1.95) (42606, 2) (61530, 2.05) (86004, 2.1) (120570, 2.15)} core_loss_type="Electrical Steel" core_loss_kh=155 core_loss_kc=0.822 mass_density=7600
  NdFe35: permittivity=1 permeability=1.0997785 conductivity=625000 magnetic_coercivity{Magnitude=-890000A_per_meter DirComp1=1 DirComp2=0 DirComp3=0} lande_g_factor=2 mass_density=7400
  vacuum: permittivity=1
  DW315_50_2DSF0.950: permeability{HUnit=A_per_meter BUnit=tesla curve (0, 0) (49, 0.380003) (52, 0.427503) (55, 0.475003) (57, 0.522504) (61, 0.570004) (64, 0.617504) (68, 0.665004) (73, 0.712505) (79, 0.760005) (84, 0.807505) (95, 0.855006) (103, 0.902506) (115, 0.950007) (124, 0.997508) (142, 1.04501) (163, 1.09251) (193, 1.14001) (235, 1.18751) (299, 1.23502) (390, 1.28252) (518, 1.33003) (796, 1.37755) (1234, 1.42508) (1990, 1.47263) (3026, 1.52019) (4299, 1.56777) (6051, 1.61538) (8962, 1.66306) (11934, 1.71075) (17950, 1.75863) (24364, 1.80653) (31052, 1.85445) (42606, 1.90268) (61530, 1.95137) (86004, 2.0004) (120570, 2.05008) (466230, 2.54679)} core_loss_type="Electrical Steel" core_loss_kh=163.158 core_loss_kc=0.865263 mass_density=7220
  NdFe35_2DSF1.000_N: CoordinateSystemType=Cylindrical permeability=1.09978 conductivity=625000 magnetic_coercivity{Magnitude=-890000A_per_meter DirComp1=1 DirComp2=0 DirComp3=0} mass_density=7400
  NdFe35_2DSF1.000_S: CoordinateSystemType=Cylindrical permeability=1.09978 conductivity=625000 magnetic_coercivity{Magnitude=-890000A_per_meter DirComp1=-1 DirComp2=0 DirComp3=0} mass_density=7400
  copper: permeability=0.999991 conductivity=58000000 mass_density=8933

design RMxprtDesign2 (RMxprt, Adjust-Speed Synchronous Machine, model units mm)
machine:
  Machine: FrictionLoss=10W WindLoss=10W ReferenceSpeed=1500rpm NumberOfPoles=4 RotorPosition=true ControlType=3 CircuitType=Y3
  Circuit: TriggerPulseWidth=120deg TransistorDrop=0V DiodeDrop=0V ModulationIndex=0 CarrierFrequencyTimes=0
  Stator: SkewWidth=0 NumberOfSlots=24 LaminationSectors=0 PressBoardThickness=0mm OuterDiameter=160mm InnerDiameter=100mm Length=60mm StackingFactor=0.95 SteelType=DW315_50 SlotType=2
  Rotor: OuterDiameter=95mm InnerDiameter=30mm Length=60mm SteelType=DW315_50 PoleType=1 StackingFactor=0.95
  Shaft:
  Stator Slot: Hs0=1mm Hs1=1.15mm Hs2=11.35mm Bs0=3mm Bs1=7mm Bs2=10mm Rs=0mm ToothWidth=0mm
  Stator Winding: WindingType=Whole-Coiled WindingLayers=2 ParallelBranches=1 ConductorsPerSlot=104 CoilPitch=5 EndAdjustment=0mm BaseInnerRadius=0mm TipInnerDiameter=0mm EndClearance=0mm CoilWrap=0mm SlotLiner=0mm WedgeThickness=0mm LayerInsulation=0mm BottomInsulation=0mm LimitedFillFactor=0.75 WdgNumberofPriodicMultipler=1 NumberOfStrands=1 WireWrap=0.084mm InterturnInsulation=0mm WireDiameter=0.8mm WireWidth=0mm WireThickness=0mm Gauge=0
  Rotor Pole: Embrace=0.72 Offset=0mm ShaftDiameter=0mm Bridge=0mm Rib=0mm MagnetThickness=5mm MagnetWidth=0mm MagnetType=NdFe35
setups:
  Setup1: ASSM Motor RatedOutputPower=1500W RatedVoltage=380V RatedSpeed=1500rpm OperatingTemperature=75cel LoadType=ConstPower RatedPowerFactor=0.75

design Maxwell2DDesign1 (Maxwell 2D, Transient, XY geometry, model units mm)
options: ComputeTransientInductance ModelDepth=60mm
variables:
  fractions = 1
  delta = 10.088247deg
  conds = 52
  R1 = 5.5472395ohm
  Le1 = 0.0039794321H
geometry:
  Band [vacuum] = user_primitive(RMxprt/Band, DiaGap=97.5mm, DiaYoke=30mm, Length=0mm, SegAngle=0deg, Fractions=1, HalfAxial=0, InfoCore=0)
  Shaft [vacuum] = user_primitive(RMxprt/Band, DiaGap=97.5mm, DiaYoke=30mm, Length=0mm, SegAngle=0deg, Fractions=1, HalfAxial=0, InfoCore=100)
  OuterRegion [vacuum] = user_primitive(RMxprt/Band, DiaGap=97.5mm, DiaYoke=160mm, Length=0mm, SegAngle=0deg, Fractions=fractions, HalfAxial=0, InfoCore=100)
  Tool = user_primitive(RMxprt/Band, DiaGap=97.5mm, DiaYoke=160mm, Length=0mm, SegAngle=0deg, Fractions=fractions, HalfAxial=0, InfoCore=1)
  Stator [DW315_50_2DSF0.950] = user_primitive(RMxprt/SlotCore, DiaGap=100mm, DiaYoke=160mm, Length=0mm, Skew=0deg, Slots=24, SlotType=2, Hs0=1mm, Hs01=0mm, Hs1=1.15mm, Hs2=11.35mm, Bs0=3mm, Bs1=7mm, Bs2=10mm, Rs=5mm, FilletType=0, HalfSlot=0, SegAngle=15deg, LenRegion=0mm, InfoCore=0)
  Coil_0 [copper] = user_primitive(RMxprt/LapCoil, DiaGap=100mm, DiaYoke=160mm, Length=0mm, Skew=0deg, Slots=24, SlotType=2, Hs0=1mm, Hs1=1.15mm, Hs2=11.35mm, Bs0=3mm, Bs1=7mm, Bs2=10mm, Rs=5mm, FilletType=0, Layers=2, CoilPitch=5, EndExt=0mm, SpanExt=0mm, BendAngle=0deg, SegAngle=10deg, LenRegion=0mm, InfoCoil=2)
  Coil_1..Coil_5 [copper], Coil_6..Coil_23 = Coil_0.duplicate_around_axis(axis=Z, angle=15deg, total=24)
  Coil_0.unite(Coil_6, Coil_12, Coil_18)
  Coil_1.unite(Coil_7, Coil_13, Coil_19)
  Coil_2.unite(Coil_8, Coil_14, Coil_20)
  Coil_3.unite(Coil_9, Coil_15, Coil_21)
  Coil_4.unite(Coil_10, Coil_16, Coil_22)
  Coil_5.unite(Coil_11, Coil_17, Coil_23)
  CoilRe_0 [copper] = user_primitive(RMxprt/LapCoil, DiaGap=100mm, DiaYoke=160mm, Length=0mm, Skew=0deg, Slots=24, SlotType=2, Hs0=1mm, Hs1=1.15mm, Hs2=11.35mm, Bs0=3mm, Bs1=7mm, Bs2=10mm, Rs=5mm, FilletType=0, Layers=2, CoilPitch=5, EndExt=0mm, SpanExt=0mm, BendAngle=0deg, SegAngle=10deg, LenRegion=0mm, InfoCoil=3)
  CoilRe_0.rotate(axis=Z, angle=-75deg)
  CoilRe_1..CoilRe_5 [copper], CoilRe_6..CoilRe_23 = CoilRe_0.duplicate_around_axis(axis=Z, angle=15deg, total=24)
  CoilRe_0.unite(CoilRe_6, CoilRe_12, CoilRe_18)
  CoilRe_1.unite(CoilRe_7, CoilRe_13, CoilRe_19)
  CoilRe_2.unite(CoilRe_8, CoilRe_14, CoilRe_20)
  CoilRe_3.unite(CoilRe_9, CoilRe_15, CoilRe_21)
  CoilRe_4.unite(CoilRe_10, CoilRe_16, CoilRe_22)
  CoilRe_5.unite(CoilRe_11, CoilRe_17, CoilRe_23)
  Rotor [DW315_50_2DSF0.950] = user_primitive(RMxprt/PMCore, DiaGap=95mm, DiaYoke=30mm, Length=0mm, Poles=4, PoleType=1, Embrace=0.72, ThickMag=5mm, WidthMag=0mm, Offset=0mm, Bridge=0mm, Rib=0mm, LenRegion=0mm, InfoCore=0)
  Mag_0 [NdFe35_2DSF1.000_N] = user_primitive(RMxprt/PMCore, DiaGap=95mm, DiaYoke=30mm, Length=0mm, Poles=4, PoleType=1, Embrace=0.72, ThickMag=5mm, WidthMag=0mm, Offset=0mm, Bridge=0mm, Rib=0mm, LenRegion=0mm, InfoCore=2)
  Mag_1, Mag_2, Mag_3 = Mag_0.duplicate_around_axis(axis=Z, angle=90deg, total=4)
  Mag_0.unite(Mag_1, Mag_2, Mag_3)
  InnerRegion [vacuum] = user_primitive(RMxprt/PMCore, DiaGap=95mm, DiaYoke=30mm, Length=0mm, Poles=4, PoleType=1, Embrace=0.72, ThickMag=5mm, WidthMag=0mm, Offset=0mm, Bridge=0mm, Rib=0mm, LenRegion=0mm, InfoCore=100)
  Tool_1 = Tool.copy()
  Band.subtract(Tool_1)
  Tool_2 = Tool.copy()
  InnerRegion.subtract(Tool_2)
  Tool_3 = Tool.copy()
  Shaft.subtract(Tool_3)
  Tool_4 = Tool.copy()
  Stator.subtract(Tool_4)
  Tool_5 = Tool.copy()
  Coil_0.subtract(Tool_5)
  Tool_6 = Tool.copy()
  Coil_1.subtract(Tool_6)
  Tool_7 = Tool.copy()
  Coil_2.subtract(Tool_7)
  Tool_8 = Tool.copy()
  Coil_3.subtract(Tool_8)
  Tool_9 = Tool.copy()
  Coil_4.subtract(Tool_9)
  Tool_10 = Tool.copy()
  Coil_5.subtract(Tool_10)
  Tool_11 = Tool.copy()
  CoilRe_0.subtract(Tool_11)
  Tool_12 = Tool.copy()
  CoilRe_1.subtract(Tool_12)
  Tool_13 = Tool.copy()
  CoilRe_2.subtract(Tool_13)
  Tool_14 = Tool.copy()
  CoilRe_3.subtract(Tool_14)
  Tool_15 = Tool.copy()
  CoilRe_4.subtract(Tool_15)
  Tool_16 = Tool.copy()
  CoilRe_5.subtract(Tool_16)
  Tool_17 = Tool.copy()
  Rotor.subtract(Tool_17)
  Mag_0.subtract(Tool)
  Polyline1 = polyline((3.3282514mm, 63.587067mm, 0mm) (13.2427mm, 62.281805mm, 0mm))
  Polyline2 = polyline(z=0mm, xy in mm: (3.3282514, 63.587067) (8.9381067, 67.89166) (13.2427, 62.281805), AngularArc from point 0 over 3 centre=(8.2854757mm, 62.934436mm, 0mm) angle=-180deg plane=XY)
  Polyline1.unite(Polyline2)
  Polyline1.cover_lines()
  Polyline1_1..Polyline1_23 = Polyline1.duplicate_around_axis(axis=Z, angle=15deg, total=24)
  Polyline1_1.unite(Polyline1_2, Polyline1_4, Polyline1_3, Polyline1_5..Polyline1_23, Polyline1)
  Stator.subtract(Polyline1_1)
motion:
  MotionSetup1: Band Move_Type=Rotate Coordinate_System=Global Axis=Z Is_Positive=true InitPos=7.5deg Angular_Velocity=1500rpm Objects=Band
  Moving1: Moving Objects=[Shaft, Rotor, Mag_0, InnerRegion]
boundaries and excitations:
  PhA_0: Coil Objects=Coil_0 Conductor_number=conds Winding=PhaseA PolarityType=Positive
  PhARe_0: Coil Objects=CoilRe_5 Conductor_number=conds Winding=PhaseA PolarityType=Negative
  PhA_1: Coil Objects=Coil_1 Conductor_number=conds Winding=PhaseA PolarityType=Positive
  PhCRe_2: Coil Objects=Coil_2 Conductor_number=conds Winding=PhaseC PolarityType=Negative
  PhCRe_3: Coil Objects=Coil_3 Conductor_number=conds Winding=PhaseC PolarityType=Negative
  PhB_4: Coil Objects=Coil_4 Conductor_number=conds Winding=PhaseB PolarityType=Positive
  PhB_5: Coil Objects=Coil_5 Conductor_number=conds Winding=PhaseB PolarityType=Positive
  PhA_19: Coil Objects=CoilRe_0 Conductor_number=conds Winding=PhaseA PolarityType=Positive
  PhCRe_20: Coil Objects=CoilRe_1 Conductor_number=conds Winding=PhaseC PolarityType=Negative
  PhCRe_21: Coil Objects=CoilRe_2 Conductor_number=conds Winding=PhaseC PolarityType=Negative
  PhB_22: Coil Objects=CoilRe_3 Conductor_number=conds Winding=PhaseB PolarityType=Positive
  PhB_23: Coil Objects=CoilRe_4 Conductor_number=conds Winding=PhaseB PolarityType=Positive
  PhaseA: Winding Group Type=Voltage IsSolid=false Current=0A Resistance=R1 Inductance=Le1 Voltage=310.269*sin(2*pi*50*time+delta) ParallelBranchesNum=1
  PhaseB: Winding Group Type=Voltage IsSolid=false Current=0A Resistance=R1 Inductance=Le1 Voltage=310.269*sin(2*pi*50*time+delta-2*pi/3) ParallelBranchesNum=1
  PhaseC: Winding Group Type=Voltage IsSolid=false Current=0A Resistance=R1 Inductance=Le1 Voltage=310.269*sin(2*pi*50*time+delta-4*pi/3) ParallelBranchesNum=1
  Y connection: PhaseA, PhaseB, PhaseC
mesh:
  SurfApprox_Mag: SurfApproxBased Objects=Mag_0 CurvedSurfaceApproxChoice=ManualSettings SurfDev=0.0475mm NormalDev=15deg
  SurfApprox_Main: SurfApproxBased Objects=[Stator, Rotor, Band, OuterRegion, InnerRegion, Shaft] CurvedSurfaceApproxChoice=ManualSettings SurfDev=0.08mm NormalDev=15deg
  CylindricalGap1: CylindricalGap Objects=Band
  initial mesh: MeshMethod=AnsoftTAU
setups:
  Setup1: Transient NonlinearSolverResidual=0.0001 StopTime=0.04s TimeStep=2e-05s SaveFieldsType=Custom SweepRanges{0s to 0.2s step 0.0002s} NumberSolveSteps=1 RangeStart=0s RangeEnd=0.1s InitialTimeStep=0.002s MinTimeStep=0.001s MaxTimeStep=0.003s TimeStepErrTolerance=0.0001
output variables:
  pos = (Moving1.Position -7.5 * PI/180) * 2 + PI
  cos0 = cos(pos)
  cos1 = cos(pos-2*PI/3)
  cos2 = cos(pos-4*PI/3)
  sin0 = sin(pos)
  sin1 = sin(pos-2*PI/3)
  sin2 = sin(pos-4*PI/3)
  Lad = L(PhaseA,PhaseA)*cos0 + L(PhaseA,PhaseB)*cos1 + L(PhaseA,PhaseC)*cos2
  Laq = L(PhaseA,PhaseA)*sin0 + L(PhaseA,PhaseB)*sin1 + L(PhaseA,PhaseC)*sin2
  Lbd = L(PhaseB,PhaseA)*cos0 + L(PhaseB,PhaseB)*cos1 + L(PhaseB,PhaseC)*cos2
  Lbq = L(PhaseB,PhaseA)*sin0 + L(PhaseB,PhaseB)*sin1 + L(PhaseB,PhaseC)*sin2
  Lcd = L(PhaseC,PhaseA)*cos0 + L(PhaseC,PhaseB)*cos1 + L(PhaseC,PhaseC)*cos2
  Lcq = L(PhaseC,PhaseA)*sin0 + L(PhaseC,PhaseB)*sin1 + L(PhaseC,PhaseC)*sin2
  L_d = (Lad*cos0 + Lbd*cos1 + Lcd*cos2) * 2/3
  L_q = (Laq*sin0 + Lbq*sin1 + Lcq*sin2) * 2/3
  Flux_d = (FluxLinkage(PhaseA)*cos0+FluxLinkage(PhaseB)*cos1+FluxLinkage(PhaseC)*cos2)*2/3
  Flux_q = (FluxLinkage(PhaseA)*sin0+FluxLinkage(PhaseB)*sin1+FluxLinkage(PhaseC)*sin2)*2/3
  I_d = (Current(PhaseA)*cos0 + Current(PhaseB)*cos1 + Current(PhaseC)*cos2)*2/3
  I_q = (Current(PhaseA)*sin0 + Current(PhaseB)*sin1 + Current(PhaseC)*sin2)*2/3
  Irms = sqrt(I_d^2+I_q^2)/sqrt(2)
  Pcu = 3*Irms^2*R1
field plots:
  Mag_B1: B over Band, Shaft, OuterRegion, Stator, Coil_0..Coil_5, CoilRe_0..CoilRe_5, Rotor, Mag_0, InnerRegion on Setup1 : Transient at Time=-1
reports:
  Torque: Moving1.Torque vs Time on Setup1 : Transient
  Currents: Current(PhaseA), Current(PhaseB), Current(PhaseC) vs Time on Setup1 : Transient
  Induced Voltages: InducedVoltage(PhaseA), InducedVoltage(PhaseB), InducedVoltage(PhaseC) vs Time on Setup1 : Transient
  Flux Linkages: FluxLinkage(PhaseA), FluxLinkage(PhaseB), FluxLinkage(PhaseC) vs Time on Setup1 : Transient
  Voltages: InputVoltage(PhaseA), InputVoltage(PhaseB), InputVoltage(PhaseC) vs Time on Setup1 : Transient
  Powers: InputVoltage(PhaseA)*Current(PhaseA) + InputVoltage(PhaseB)*Current(PhaseB) + InputVoltage(PhaseC)*Current(PhaseC), Moving1.Speed*Moving1.Torque vs Time on Setup1 : Transient
  L_dq: L_d, L_q vs Time on Setup1 : Transient
  Flux_dq: Flux_d, Flux_q vs Time on Setup1 : Transient
  I_dq: I_d, I_q vs Time on Setup1 : Transient

design Maxwell2DDesign2 (Maxwell 2D, Transient, XY geometry, model units mm)
options: ComputeTransientInductance ModelDepth=60mm
variables:
  fractions = 1
  delta = 10.088247deg
  conds = 52
  R1 = 5.5472395ohm
  Le1 = 0.0039794321H
geometry:
  Tool = user_primitive(RMxprt/Band, DiaGap=97.5mm, DiaYoke=160mm, Length=0mm, SegAngle=0deg, Fractions=fractions, HalfAxial=0, InfoCore=1)
  Stator [DW315_50_2DSF0.950] = user_primitive(RMxprt/SlotCore, DiaGap=100mm, DiaYoke=160mm, Length=0mm, Skew=0deg, Slots=24, SlotType=2, Hs0=1mm, Hs01=0mm, Hs1=1.15mm, Hs2=11.35mm, Bs0=3mm, Bs1=7mm, Bs2=10mm, Rs=5mm, FilletType=0, HalfSlot=0, SegAngle=15deg, LenRegion=0mm, InfoCore=0)
  Mag_0 = user_primitive(RMxprt/PMCore, DiaGap=95mm, DiaYoke=30mm, Length=0mm, Poles=4, PoleType=1, Embrace=0.72, ThickMag=5mm, WidthMag=0mm, Offset=0mm, Bridge=0mm, Rib=0mm, LenRegion=0mm, InfoCore=2)
  Mag_1, Mag_2, Mag_3 = Mag_0.duplicate_around_axis(axis=Z, angle=90deg, total=4)
  Mag_0.unite(Mag_1, Mag_2, Mag_3)
  Tool_4 = Tool.copy()
  Stator.subtract(Tool_4)
  Mag_0.subtract(Tool)
  Polyline1 = polyline((3.3282514mm, 63.587067mm, 0mm) (13.2427mm, 62.281805mm, 0mm))
  Polyline2 = polyline(z=0mm, xy in mm: (3.3282514, 63.587067) (8.9381067, 67.89166) (13.2427, 62.281805), AngularArc from point 0 over 3 centre=(8.2854757mm, 62.934436mm, 0mm) angle=-180deg plane=XY)
  Polyline1.unite(Polyline2)
  Polyline1.cover_lines()
  Polyline1_1..Polyline1_23 = Polyline1.duplicate_around_axis(axis=Z, angle=15deg, total=24)
  Polyline1_1.unite(Polyline1_2, Polyline1_4, Polyline1_3, Polyline1_5..Polyline1_23, Polyline1)
  Stator.subtract(Polyline1_1)
  Stator_Outer = imported_body()
  Rotor_Outer [DW315_50_2DSF0.950] = circle(normal=Z, centre=(0mm, 0mm, 0mm), radius=47.5mm)
  Circle2 = circle(normal=Z, centre=(0mm, 0mm, 0mm), radius=15mm)
  Key = rectangle(corner=(-3mm, 0mm, 0mm), x_size=6mm, y_size=18mm)
  Polyline3 = polyline(z=0mm, xy in mm: (-3, 18) (3, 18) (3, 18.3) (-3, 18), closed, covered)
  Key.unite(Polyline3)
  Rotor_Outer.subtract(Circle2, Key)
  Number [DW315_50_2DSF0.950] = rectangle(corner=(56.5mm, 80mm, 0mm), x_size=2mm, y_size=-3.5mm)
  Rectangle6 = rectangle(corner=(60.5mm, 80mm, 0mm), x_size=2mm, y_size=-3.5mm)
  Rectangle7 = rectangle(corner=(64.5mm, 80mm, 0mm), x_size=2mm, y_size=-3.5mm)
  Rectangle8 = rectangle(corner=(68.5mm, 80mm, 0mm), x_size=2mm, y_size=-3.5mm)
  Rectangle9 = rectangle(corner=(72.5mm, 80mm, 0mm), x_size=2mm, y_size=-3.5mm)
  Number.unite(Rectangle6..Rectangle9)
  Stator.unite(Stator_Outer)
  Rotor_Outer.subtract(Mag_0)
  Polyline4 [vacuum] = polyline(z=0mm, xy in mm: (56.5, 80) (57.5, 76.5) (58.5, 80) (56.5, 80), closed, covered)
  Polyline5 = polyline(z=0mm, xy in mm: (56.5, 80) (57.5, 76.5) (58.5, 80) (56.5, 80), closed, covered)
  Polyline6 = polyline(z=0mm, xy in mm: (60.5, 80) (61.5, 76.5) (62.5, 80) (60.5, 80), closed, covered)
  Polyline7 = polyline(z=0mm, xy in mm: (64.5, 80) (65.5, 76.5) (66.5, 80) (64.5, 80), closed, covered)
  Polyline8 = polyline(z=0mm, xy in mm: (68.5, 80) (69.5, 76.5) (70.5, 80) (68.5, 80), closed, covered)
  Stator.subtract(Polyline5)
  Stator.subtract(Polyline6)
  Stator.subtract(Polyline7)
  Stator.subtract(Polyline8)
boundaries and excitations:
  PhaseA: Winding Group Type=Voltage IsSolid=false Current=0A Resistance=R1 Inductance=Le1 Voltage=310.269*sin(2*pi*50*time+delta) ParallelBranchesNum=1
  PhaseB: Winding Group Type=Voltage IsSolid=false Current=0A Resistance=R1 Inductance=Le1 Voltage=310.269*sin(2*pi*50*time+delta-2*pi/3) ParallelBranchesNum=1
  PhaseC: Winding Group Type=Voltage IsSolid=false Current=0A Resistance=R1 Inductance=Le1 Voltage=310.269*sin(2*pi*50*time+delta-4*pi/3) ParallelBranchesNum=1
  Y connection: PhaseA, PhaseB, PhaseC
mesh:
  SurfApprox_Main: SurfApproxBased Objects=Stator CurvedSurfaceApproxChoice=ManualSettings SurfDev=0.08mm NormalDev=15deg
  initial mesh: MeshMethod=AnsoftTAU
setups:
  Setup1: Transient NonlinearSolverResidual=0.0001 StopTime=0.04s TimeStep=2e-05s SaveFieldsType=Custom SweepRanges{0s to 0.2s step 0.0002s} NumberSolveSteps=1 RangeStart=0s RangeEnd=0.1s InitialTimeStep=0.002s MinTimeStep=0.001s MaxTimeStep=0.003s TimeStepErrTolerance=0.0001
output variables:
  pos = (Moving1.Position -7.5 * PI/180) * 2 + PI
  cos0 = cos(pos)
  cos1 = cos(pos-2*PI/3)
  cos2 = cos(pos-4*PI/3)
  sin0 = sin(pos)
  sin1 = sin(pos-2*PI/3)
  sin2 = sin(pos-4*PI/3)
  Lad = L(PhaseA,PhaseA)*cos0 + L(PhaseA,PhaseB)*cos1 + L(PhaseA,PhaseC)*cos2
  Laq = L(PhaseA,PhaseA)*sin0 + L(PhaseA,PhaseB)*sin1 + L(PhaseA,PhaseC)*sin2
  Lbd = L(PhaseB,PhaseA)*cos0 + L(PhaseB,PhaseB)*cos1 + L(PhaseB,PhaseC)*cos2
  Lbq = L(PhaseB,PhaseA)*sin0 + L(PhaseB,PhaseB)*sin1 + L(PhaseB,PhaseC)*sin2
  Lcd = L(PhaseC,PhaseA)*cos0 + L(PhaseC,PhaseB)*cos1 + L(PhaseC,PhaseC)*cos2
  Lcq = L(PhaseC,PhaseA)*sin0 + L(PhaseC,PhaseB)*sin1 + L(PhaseC,PhaseC)*sin2
  L_d = (Lad*cos0 + Lbd*cos1 + Lcd*cos2) * 2/3
  L_q = (Laq*sin0 + Lbq*sin1 + Lcq*sin2) * 2/3
  Flux_d = (FluxLinkage(PhaseA)*cos0+FluxLinkage(PhaseB)*cos1+FluxLinkage(PhaseC)*cos2)*2/3
  Flux_q = (FluxLinkage(PhaseA)*sin0+FluxLinkage(PhaseB)*sin1+FluxLinkage(PhaseC)*sin2)*2/3
  I_d = (Current(PhaseA)*cos0 + Current(PhaseB)*cos1 + Current(PhaseC)*cos2)*2/3
  I_q = (Current(PhaseA)*sin0 + Current(PhaseB)*sin1 + Current(PhaseC)*sin2)*2/3
  Irms = sqrt(I_d^2+I_q^2)/sqrt(2)
  Pcu = 3*Irms^2*R1
field plots:
  Mag_B1: B over Stator on Setup1 : Transient at Time=-1
reports:
  Torque: Moving1.Torque vs Time on Setup1 : Transient
  Currents: Current(PhaseA), Current(PhaseB), Current(PhaseC) vs Time on Setup1 : Transient
  Induced Voltages: InducedVoltage(PhaseA), InducedVoltage(PhaseB), InducedVoltage(PhaseC) vs Time on Setup1 : Transient
  Flux Linkages: FluxLinkage(PhaseA), FluxLinkage(PhaseB), FluxLinkage(PhaseC) vs Time on Setup1 : Transient
  Voltages: InputVoltage(PhaseA), InputVoltage(PhaseB), InputVoltage(PhaseC) vs Time on Setup1 : Transient
  Powers: InputVoltage(PhaseA)*Current(PhaseA) + InputVoltage(PhaseB)*Current(PhaseB) + InputVoltage(PhaseC)*Current(PhaseC), Moving1.Speed*Moving1.Torque vs Time on Setup1 : Transient
  L_dq: L_d, L_q vs Time on Setup1 : Transient
  Flux_dq: Flux_d, Flux_q vs Time on Setup1 : Transient
  I_dq: I_d, I_q vs Time on Setup1 : Transient

design Maxwell2DDesign3 (Maxwell 2D, Transient, XY geometry, model units mm)
options: ComputeTransientInductance ModelDepth=60mm
variables:
  fractions = 1
  delta = 10.088247deg
  conds = 52
  R1 = 5.5472395ohm
  Le1 = 0.0039794321H
geometry:
  Tool = user_primitive(RMxprt/Band, DiaGap=97.5mm, DiaYoke=160mm, Length=0mm, SegAngle=0deg, Fractions=fractions, HalfAxial=0, InfoCore=1)
  Mag_0 [NdFe35_2DSF1.000_N] = user_primitive(RMxprt/PMCore, DiaGap=95mm, DiaYoke=30mm, Length=0mm, Poles=4, PoleType=1, Embrace=0.72, ThickMag=5mm, WidthMag=0mm, Offset=0mm, Bridge=0mm, Rib=0mm, LenRegion=0mm, InfoCore=2)
  Tool.delete()
  Mag_0.rotate(axis=Z, angle=45deg)
boundaries and excitations:
  PhaseA: Winding Group Type=Voltage IsSolid=false Current=0A Resistance=R1 Inductance=Le1 Voltage=310.269*sin(2*pi*50*time+delta) ParallelBranchesNum=1
  PhaseB: Winding Group Type=Voltage IsSolid=false Current=0A Resistance=R1 Inductance=Le1 Voltage=310.269*sin(2*pi*50*time+delta-2*pi/3) ParallelBranchesNum=1
  PhaseC: Winding Group Type=Voltage IsSolid=false Current=0A Resistance=R1 Inductance=Le1 Voltage=310.269*sin(2*pi*50*time+delta-4*pi/3) ParallelBranchesNum=1
  Y connection: PhaseA, PhaseB, PhaseC
mesh:
  SurfApprox_Mag: SurfApproxBased Objects=Mag_0 CurvedSurfaceApproxChoice=ManualSettings SurfDev=0.0475mm NormalDev=15deg
  initial mesh: MeshMethod=AnsoftTAU
setups:
  Setup1: Transient NonlinearSolverResidual=0.0001 StopTime=0.04s TimeStep=2e-05s SaveFieldsType=Custom SweepRanges{0s to 0.2s step 0.0002s} NumberSolveSteps=1 RangeStart=0s RangeEnd=0.1s InitialTimeStep=0.002s MinTimeStep=0.001s MaxTimeStep=0.003s TimeStepErrTolerance=0.0001
output variables:
  pos = (Moving1.Position -7.5 * PI/180) * 2 + PI
  cos0 = cos(pos)
  cos1 = cos(pos-2*PI/3)
  cos2 = cos(pos-4*PI/3)
  sin0 = sin(pos)
  sin1 = sin(pos-2*PI/3)
  sin2 = sin(pos-4*PI/3)
  Lad = L(PhaseA,PhaseA)*cos0 + L(PhaseA,PhaseB)*cos1 + L(PhaseA,PhaseC)*cos2
  Laq = L(PhaseA,PhaseA)*sin0 + L(PhaseA,PhaseB)*sin1 + L(PhaseA,PhaseC)*sin2
  Lbd = L(PhaseB,PhaseA)*cos0 + L(PhaseB,PhaseB)*cos1 + L(PhaseB,PhaseC)*cos2
  Lbq = L(PhaseB,PhaseA)*sin0 + L(PhaseB,PhaseB)*sin1 + L(PhaseB,PhaseC)*sin2
  Lcd = L(PhaseC,PhaseA)*cos0 + L(PhaseC,PhaseB)*cos1 + L(PhaseC,PhaseC)*cos2
  Lcq = L(PhaseC,PhaseA)*sin0 + L(PhaseC,PhaseB)*sin1 + L(PhaseC,PhaseC)*sin2
  L_d = (Lad*cos0 + Lbd*cos1 + Lcd*cos2) * 2/3
  L_q = (Laq*sin0 + Lbq*sin1 + Lcq*sin2) * 2/3
  Flux_d = (FluxLinkage(PhaseA)*cos0+FluxLinkage(PhaseB)*cos1+FluxLinkage(PhaseC)*cos2)*2/3
  Flux_q = (FluxLinkage(PhaseA)*sin0+FluxLinkage(PhaseB)*sin1+FluxLinkage(PhaseC)*sin2)*2/3
  I_d = (Current(PhaseA)*cos0 + Current(PhaseB)*cos1 + Current(PhaseC)*cos2)*2/3
  I_q = (Current(PhaseA)*sin0 + Current(PhaseB)*sin1 + Current(PhaseC)*sin2)*2/3
  Irms = sqrt(I_d^2+I_q^2)/sqrt(2)
  Pcu = 3*Irms^2*R1
field plots:
  Mag_B1: B over Mag_0 on Setup1 : Transient at Time=-1
reports:
  Torque: Moving1.Torque vs Time on Setup1 : Transient
  Currents: Current(PhaseA), Current(PhaseB), Current(PhaseC) vs Time on Setup1 : Transient
  Induced Voltages: InducedVoltage(PhaseA), InducedVoltage(PhaseB), InducedVoltage(PhaseC) vs Time on Setup1 : Transient
  Flux Linkages: FluxLinkage(PhaseA), FluxLinkage(PhaseB), FluxLinkage(PhaseC) vs Time on Setup1 : Transient
  Voltages: InputVoltage(PhaseA), InputVoltage(PhaseB), InputVoltage(PhaseC) vs Time on Setup1 : Transient
  Powers: InputVoltage(PhaseA)*Current(PhaseA) + InputVoltage(PhaseB)*Current(PhaseB) + InputVoltage(PhaseC)*Current(PhaseC), Moving1.Speed*Moving1.Torque vs Time on Setup1 : Transient
  L_dq: L_d, L_q vs Time on Setup1 : Transient
  Flux_dq: Flux_d, Flux_q vs Time on Setup1 : Transient
  I_dq: I_d, I_q vs Time on Setup1 : Transient
