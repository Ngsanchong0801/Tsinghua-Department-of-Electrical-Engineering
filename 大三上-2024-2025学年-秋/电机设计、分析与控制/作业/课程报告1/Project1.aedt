# Ansys Electronics Desktop project, version 2022.1
materials:
  DW315_50: permeability{HUnit=A_per_meter BUnit=tesla curve (0, 0) (49, 0.4) (52, 0.45) (55, 0.5) (57, 0.55) (61, 0.6) (64, 0.65) (68, 0.7) (73, 0.75) (79, 0.8) (84, 0.85) (95, 0.9) (103, 0.95) (115, 1) (124, 1.05) (142, 1.1) (163, 1.15) (193, 1.2) (235, 1.25) (299, 1.3) (390, 1.35) (518, 1.4) (796, 1.45) (1234, 1.5) (1990, 1.55) (3026, 1.6) (4299, 1.65) (6051, 1.7) (8962, 1.75) (11934, 1.8) (17950, 1.85) (24364, 1.9) (31052, 1.95) (42606, 2) (61530, 2.05) (86004, 2.1) (120570, 2.15)} core_loss_type="Electrical Steel" core_loss_kh=155 core_loss_kc=0.822 mass_density=7600
  NdFe35: permittivity=1 permeability=1.0997785 conductivity=625000 magnetic_coercivity{Magnitude=-890000A_per_meter DirComp1=1 DirComp2=0 DirComp3=0} lande_g_factor=2 mass_density=7400
  vacuum: permittivity=1
  DW315_50_2DSF0.960: permeability{HUnit=A_per_meter BUnit=tesla curve (0, 0) (49, 0.384002) (52, 0.432003) (55, 0.480003) (57, 0.528003) (61, 0.576003) (64, 0.624003) (68, 0.672003) (73, 0.720004) (79, 0.768004) (84, 0.816004) (95, 0.864005) (103, 0.912005) (115, 0.960006) (124, 1.00801) (142, 1.05601) (163, 1.10401) (193, 1.15201) (235, 1.20001) (299, 1.24802) (390, 1.29602) (518, 1.34403) (796, 1.39204) (1234, 1.44006) (1990, 1.4881) (3026, 1.53615) (4299, 1.58422) (6051, 1.6323) (8962, 1.68045) (11934, 1.7286) (17950, 1.7769) (24364, 1.82522) (31052, 1.87356) (42606, 1.92214) (61530, 1.97109) (86004, 2.02032) (120570, 2.07006) (466230, 2.56744)} core_loss_type="Electrical Steel" core_loss_kh=161.458 core_loss_kc=0.85625 mass_density=7296
  DW315_50_2DSF0.950: permeability{HUnit=A_per_meter BUnit=tesla curve (0, 0) (49, 0.380003) (52, 0.427503) (55, 0.475003) (57, 0.522504) (61, 0.570004) (64, 0.617504) (68, 0.665004) (73, 0.712505) (79, 0.760005) (84, 0.807505) (95, 0.855006) (103, 0.902506) (115, 0.950007) (124, 0.997508) (142, 1.04501) (163, 1.09251) (193, 1.14001) (235, 1.18751) (299, 1.23502) (390, 1.28252) (518, 1.33003) (796, 1.37755) (1234, 1.42508) (1990, 1.47263) (3026, 1.52019) (4299, 1.56777) (6051, 1.61538) (8962, 1.66306) (11934, 1.71075) (17950, 1.75863) (24364, 1.80653) (31052, 1.85445) (42606, 1.90268) (61530, 1.95137) (86004, 2.0004) (120570, 2.05008) (466230, 2.54679)} core_loss_type="Electrical Steel" core_loss_kh=163.158 core_loss_kc=0.865263 mass_density=7220
  NdFe35_2DSF1.000_N: CoordinateSystemType=Cylindrical permeability=1.09978 conductivity=625000 magnetic_coercivity{Magnitude=-890000A_per_meter DirComp1=1 DirComp2=0 DirComp3=0} mass_density=7400
  NdFe35_2DSF1.000_S: CoordinateSystemType=Cylindrical permeability=1.09978 conductivity=625000 magnetic_coercivity{Magnitude=-890000A_per_meter DirComp1=-1 DirComp2=0 DirComp3=0} mass_density=7400
  copper: permeability=0.999991 conductivity=58000000 mass_density=8933

design Maxwell2DDesign1 (Maxwell 2D, Transient, XY geometry, model units mm)
options: ComputeTransientInductance ModelDepth=60mm
variables:
  fractions = 4
  thickness = 5.2mm
  delta = 14.679285deg
  conds = 99
  R1 = 15.137837ohm
  Le1 = 0.021148396H
geometry:
  Band [vacuum] = user_primitive(RMxprt/Band, DiaGap=106mm, DiaYoke=30mm, Length=0mm, SegAngle=0deg, Fractions=1, HalfAxial=0, InfoCore=0)
  Shaft [vacuum] = user_primitive(RMxprt/Band, DiaGap=106mm, DiaYoke=30mm, Length=0mm, SegAngle=0deg, Fractions=1, HalfAxial=0, InfoCore=100)
  OuterRegion [vacuum] = user_primitive(RMxprt/Band, DiaGap=106mm, DiaYoke=160mm, Length=0mm, SegAngle=0deg, Fractions=fractions, HalfAxial=0, InfoCore=100)
  Tool = user_primitive(RMxprt/Band, DiaGap=106mm, DiaYoke=160mm, Length=0mm, SegAngle=0deg, Fractions=fractions, HalfAxial=0, InfoCore=1)
  Stator [DW315_50_2DSF0.950] = user_primitive(RMxprt/SlotCore, DiaGap=112mm, DiaYoke=160mm, Length=0mm, Skew=0deg, Slots=24, SlotType=2, Hs0=1mm, Hs01=0mm, Hs1=2mm, Hs2=13.8mm, Bs0=2mm, Bs1=7.2mm, Bs2=10.4mm, Rs=5.2mm, FilletType=0, HalfSlot=0, SegAngle=15deg, LenRegion=0mm, InfoCore=0)
  Coil_0 [copper] = user_primitive(RMxprt/LapCoil, DiaGap=112mm, DiaYoke=160mm, Length=0mm, Skew=0deg, Slots=24, SlotType=2, Hs0=1mm, Hs1=2mm, Hs2=13.8mm, Bs0=2mm, Bs1=7.2mm, Bs2=10.4mm, Rs=5.2mm, FilletType=0, Layers=2, CoilPitch=5, EndExt=0mm, SpanExt=0mm, BendAngle=0deg, SegAngle=10deg, LenRegion=0mm, InfoCoil=2)
  Coil_1..Coil_5 [copper], Coil_6..Coil_23 = Coil_0.duplicate_around_axis(axis=Z, angle=15deg, total=24)
  Coil_0.unite(Coil_6, Coil_12, Coil_18)
  Coil_1.unite(Coil_7, Coil_13, Coil_19)
  Coil_2.unite(Coil_8, Coil_14, Coil_20)
  Coil_3.unite(Coil_9, Coil_15, Coil_21)
  Coil_4.unite(Coil_10, Coil_16, Coil_22)
  Coil_5.unite(Coil_11, Coil_17, Coil_23)
  CoilRe_0 [copper] = user_primitive(RMxprt/LapCoil, DiaGap=112mm, DiaYoke=160mm, Length=0mm, Skew=0deg, Slots=24, SlotType=2, Hs0=1mm, Hs1=2mm, Hs2=13.8mm, Bs0=2mm, Bs1=7.2mm, Bs2=10.4mm, Rs=5.2mm, FilletType=0, Layers=2, CoilPitch=5, EndExt=0mm, SpanExt=0mm, BendAngle=0deg, SegAngle=10deg, LenRegion=0mm, InfoCoil=3)
  CoilRe_0.rotate(axis=Z, angle=-75deg)
  CoilRe_1..CoilRe_5 [copper], CoilRe_6..CoilRe_23 = CoilRe_0.duplicate_around_axis(axis=Z, angle=15deg, total=24)
  CoilRe_0.unite(CoilRe_6, CoilRe_12, CoilRe_18)
  CoilRe_1.unite(CoilRe_7, CoilRe_13, CoilRe_19)
  CoilRe_2.unite(CoilRe_8, CoilRe_14, CoilRe_20)
  CoilRe_3.unite(CoilRe_9, CoilRe_15, CoilRe_21)
  CoilRe_4.unite(CoilRe_10, CoilRe_16, CoilRe_22)
  CoilRe_5.unite(CoilRe_11, CoilRe_17, CoilRe_23)
  Rotor [DW315_50_2DSF0.950] = user_primitive(RMxprt/PMCore, DiaGap=100mm, DiaYoke=30mm, Length=0mm, Poles=4, PoleType=1, Embrace=0.7, ThickMag=9.5mm, WidthMag=26mm, Offset=0mm, Bridge=1mm, Rib=4mm, LenRegion=0mm, InfoCore=0)
  Mag_0 [NdFe35_2DSF1.000_N] = user_primitive(RMxprt/PMCore, DiaGap=100mm, DiaYoke=30mm, Length=0mm, Poles=4, PoleType=1, Embrace=0.7, ThickMag=9.5mm, WidthMag=26mm, Offset=0mm, Bridge=1mm, Rib=4mm, LenRegion=0mm, InfoCore=2)
  Mag_1, Mag_2, Mag_3 = Mag_0.duplicate_around_axis(axis=Z, angle=90deg, total=4)
  Mag_0.unite(Mag_1, Mag_2, Mag_3)
  InnerRegion [vacuum] = user_primitive(RMxprt/PMCore, DiaGap=100mm, DiaYoke=30mm, Length=0mm, Poles=4, PoleType=1, Embrace=0.7, ThickMag=9.5mm, WidthMag=26mm, Offset=0mm, Bridge=1mm, Rib=4mm, LenRegion=0mm, InfoCore=100)
  Tool_1 = Tool.copy()
  Band.subtract(Tool_1)
  Tool_2 = Tool.copy()
  InnerRegion.subtract(Tool_2)
  Tool_3 = Tool.copy()
  Shaft.subtract(Tool_3)
  Tool_4 = Tool.copy()
  Stator.subtract(Tool_4)
  Tool_5 = Tool.copy()
  Coil_0.subtract(Tool_5)
  Tool_6 = Tool.copy()
  Coil_1.subtract(Tool_6)
  Tool_7 = Tool.copy()
  Coil_2.subtract(Tool_7)
  Tool_8 = Tool.copy()
  Coil_3.subtract(Tool_8)
  Tool_9 = Tool.copy()
  Coil_4.subtract(Tool_9)
  Tool_10 = Tool.copy()
  Coil_5.subtract(Tool_10)
  Tool_11 = Tool.copy()
  CoilRe_0.subtract(Tool_11)
  Tool_12 = Tool.copy()
  CoilRe_1.subtract(Tool_12)
  Tool_13 = Tool.copy()
  CoilRe_2.subtract(Tool_13)
  Tool_14 = Tool.copy()
  CoilRe_3.subtract(Tool_14)
  Tool_15 = Tool.copy()
  CoilRe_4.subtract(Tool_15)
  Tool_16 = Tool.copy()
  CoilRe_5.subtract(Tool_16)
  Tool_17 = Tool.copy()
  Rotor.subtract(Tool_17)
  Mag_0.subtract(Tool)
motion:
  MotionSetup1: Band Move_Type=Rotate Coordinate_System=Global Axis=Z Is_Positive=true InitPos=7.5deg Angular_Velocity=1500rpm Objects=Band
  Moving1: Moving Objects=[Shaft, Rotor, Mag_0, InnerRegion]
boundaries and excitations:
  VectorPotential1: Vector Potential Edges=OuterRegion.edge(at (56.5685, 56.5685, 0)) Value=0
  Independent1: Independent Edges=OuterRegion.edge(at (40, 0, 0))
  Dependent1: Dependent Edges=OuterRegion.edge(at (0, 40, 0)) ReverseU Independent=Independent1 SameAsMaster=false
  PhA_0: Coil Objects=Coil_0 Conductor_number=conds Winding=PhaseA PolarityType=Positive
  PhARe_0: Coil Objects=CoilRe_5 Conductor_number=conds Winding=PhaseA PolarityType=Negative
  PhA_1: Coil Objects=Coil_1 Conductor_number=conds Winding=PhaseA PolarityType=Positive
  PhCRe_2: Coil Objects=Coil_2 Conductor_number=conds Winding=PhaseC PolarityType=Negative
  PhCRe_3: Coil Objects=Coil_3 Conductor_number=conds Winding=PhaseC PolarityType=Negative
  PhB_4: Coil Objects=Coil_4 Conductor_number=conds Winding=PhaseB PolarityType=Positive
  PhB_5: Coil Objects=Coil_5 Conductor_number=conds Winding=PhaseB PolarityType=Positive
  PhA_19: Coil Objects=CoilRe_0 Conductor_number=conds Winding=PhaseA PolarityType=Positive
  PhCRe_20: Coil Objects=CoilRe_1 Conductor_number=conds Winding=PhaseC PolarityType=Negative
  PhCRe_21: Coil Objects=CoilRe_2 Conductor_number=conds Winding=PhaseC PolarityType=Negative
  PhB_22: Coil Objects=CoilRe_3 Conductor_number=conds Winding=PhaseB PolarityType=Positive
  PhB_23: Coil Objects=CoilRe_4 Conductor_number=conds Winding=PhaseB PolarityType=Positive
  PhaseA: Winding Group Type=Voltage IsSolid=false Current=0A Resistance=R1 Inductance=Le1 Voltage=310.269*sin(2*pi*50*time+delta) ParallelBranchesNum=1
  PhaseB: Winding Group Type=Voltage IsSolid=false Current=0A Resistance=R1 Inductance=Le1 Voltage=310.269*sin(2*pi*50*time+delta-2*pi/3) ParallelBranchesNum=1
  PhaseC: Winding Group Type=Voltage IsSolid=false Current=0A Resistance=R1 Inductance=Le1 Voltage=310.269*sin(2*pi*50*time+delta-4*pi/3) ParallelBranchesNum=1
  Y connection: PhaseA, PhaseB, PhaseC
mesh:
  SurfApprox_Mag: SurfApproxBased Objects=Mag_0 CurvedSurfaceApproxChoice=ManualSettings SurfDev=0.05mm NormalDev=15deg
  SurfApprox_Main: SurfApproxBased Objects=[Stator, Rotor, Band, OuterRegion, InnerRegion, Shaft] CurvedSurfaceApproxChoice=ManualSettings SurfDev=0.08mm NormalDev=15deg
  CylindricalGap1: CylindricalGap Objects=Band
  initial mesh: MeshMethod=AnsoftTAU
setups:
  Setup1: Transient NonlinearSolverResidual=0.0001 StopTime=0.04s TimeStep=0.0002s SaveFieldsType=Custom SweepRanges{0s to 0.04s step 0.0002s} NumberSolveSteps=1 RangeStart=0s RangeEnd=0.1s InitialTimeStep=0.002s MinTimeStep=0.001s MaxTimeStep=0.003s TimeStepErrTolerance=0.0001
output variables:
  pos = (Moving1.Position -7.5 * PI/180) * 2 + PI
  cos0 = cos(pos)
  cos1 = cos(pos-2*PI/3)
  cos2 = cos(pos-4*PI/3)
  sin0 = sin(pos)
  sin1 = sin(pos-2*PI/3)
  sin2 = sin(pos-4*PI/3)
  Lad = L(PhaseA,PhaseA)*cos0 + L(PhaseA,PhaseB)*cos1 + L(PhaseA,PhaseC)*cos2
  Laq = L(PhaseA,PhaseA)*sin0 + L(PhaseA,PhaseB)*sin1 + L(PhaseA,PhaseC)*sin2
  Lbd = L(PhaseB,PhaseA)*cos0 + L(PhaseB,PhaseB)*cos1 + L(PhaseB,PhaseC)*cos2
  Lbq = L(PhaseB,PhaseA)*sin0 + L(PhaseB,PhaseB)*sin1 + L(PhaseB,PhaseC)*sin2
  Lcd = L(PhaseC,PhaseA)*cos0 + L(PhaseC,PhaseB)*cos1 + L(PhaseC,PhaseC)*cos2
  Lcq = L(PhaseC,PhaseA)*sin0 + L(PhaseC,PhaseB)*sin1 + L(PhaseC,PhaseC)*sin2
  L_d = (Lad*cos0 + Lbd*cos1 + Lcd*cos2) * 2/3
  L_q = (Laq*sin0 + Lbq*sin1 + Lcq*sin2) * 2/3
  Flux_d = (FluxLinkage(PhaseA)*cos0+FluxLinkage(PhaseB)*cos1+FluxLinkage(PhaseC)*cos2)*2/3
  Flux_q = (FluxLinkage(PhaseA)*sin0+FluxLinkage(PhaseB)*sin1+FluxLinkage(PhaseC)*sin2)*2/3
  I_d = (Current(PhaseA)*cos0 + Current(PhaseB)*cos1 + Current(PhaseC)*cos2)*2/3
  I_q = (Current(PhaseA)*sin0 + Current(PhaseB)*sin1 + Current(PhaseC)*sin2)*2/3
  Irms = sqrt(I_d^2+I_q^2)/sqrt(2)
  Pcu = 3*Irms^2*R1
reports:
  Torque: Moving1.Torque vs Time on Setup1 : Transient
  Currents: Current(PhaseA), Current(PhaseB), Current(PhaseC) vs Time on Setup1 : Transient
  Induced Voltages: InducedVoltage(PhaseA), InducedVoltage(PhaseB), InducedVoltage(PhaseC) vs Time on Setup1 : Transient
  Flux Linkages: FluxLinkage(PhaseA), FluxLinkage(PhaseB), FluxLinkage(PhaseC) vs Time on Setup1 : Transient
  Voltages: InputVoltage(PhaseA), InputVoltage(PhaseB), InputVoltage(PhaseC) vs Time on Setup1 : Transient
  Powers: InputVoltage(PhaseA)*Current(PhaseA) + InputVoltage(PhaseB)*Current(PhaseB) + InputVoltage(PhaseC)*Current(PhaseC), Moving1.Speed*Moving1.Torque vs Time on Setup1 : Transient
  L_dq: L_d, L_q vs Time on Setup1 : Transient
  Flux_dq: Flux_d, Flux_q vs Time on Setup1 : Transient
  I_dq: I_d, I_q vs Time on Setup1 : Transient

design RMxprtDesign1 (RMxprt, Adjust-Speed Synchronous Machine, model units mm)
variables:
  thickness = 5.2mm
machine:
  Machine: FrictionLoss=10W WindLoss=10W ReferenceSpeed=1500rpm NumberOfPoles=4 RotorPosition=true ControlType=3 CircuitType=Y3
  Circuit: TriggerPulseWidth=120deg TransistorDrop=0V DiodeDrop=0V ModulationIndex=0 CarrierFrequencyTimes=0
  Stator: SkewWidth=0 NumberOfSlots=24 LaminationSectors=0 PressBoardThickness=0mm OuterDiameter=160mm InnerDiameter=112mm Length=60mm StackingFactor=0.95 SteelType=DW315_50 SlotType=2
  Rotor: OuterDiameter=110mm InnerDiameter=30mm Length=60mm SteelType=DW315_50 PoleType=1 StackingFactor=0.95
  Shaft:
  Stator Slot: Hs0=1mm Hs1=2mm Hs2=13.8mm Bs0=2mm Bs1=7.2mm Bs2=10.4mm Rs=0mm ToothWidth=9.5mm
  Stator Winding: WindingType=Whole-Coiled WindingLayers=2 ParallelBranches=1 ConductorsPerSlot=198 CoilPitch=5 EndAdjustment=0mm BaseInnerRadius=0mm TipInnerDiameter=0mm EndClearance=0mm CoilWrap=0mm SlotLiner=0mm WedgeThickness=0mm LayerInsulation=0mm BottomInsulation=0mm LimitedFillFactor=0.75 WdgNumberofPriodicMultipler=1 NumberOfStrands=1 WireWrap=0.079mm InterturnInsulation=0mm WireDiameter=0.69mm WireWidth=0mm WireThickness=0mm Gauge=0
  Rotor Pole: Embrace=0.7 Offset=0mm ShaftDiameter=0mm Bridge=1mm Rib=4mm MagnetThickness=9.2mm MagnetWidth=26mm MagnetType=NdFe35
setups:
  Setup1: ASSM Motor RatedOutputPower=1000W RatedVoltage=380V RatedSpeed=1500rpm OperatingTemperature=75cel LoadType=ConstPower RatedPowerFactor=0.75
output variables:
  efficiency = OutputPowerParameter/InputPowerParameter
