# Ansys Electronics Desktop project, version 2022.1
materials:
  DW315_50_2DSF0.950: permeability{HUnit=A_per_meter BUnit=tesla curve (0, 0) (49, 0.380003) (52, 0.427503) (55, 0.475003) (57, 0.522504) (61, 0.570004) (64, 0.617504) (68, 0.665004) (73, 0.712505) (79, 0.760005) (84, 0.807505) (95, 0.855006) (103, 0.902506) (115, 0.950007) (124, 0.997508) (142, 1.04501) (163, 1.09251) (193, 1.14001) (235, 1.18751) (299, 1.23502) (390, 1.28252) (518, 1.33003) (796, 1.37755) (1234, 1.42508) (1990, 1.47263) (3026, 1.52019) (4299, 1.56777) (6051, 1.61538) (8962, 1.66306) (11934, 1.71075) (17950, 1.75863) (24364, 1.80653) (31052, 1.85445) (42606, 1.90268) (61530, 1.95137) (86004, 2.0004) (120570, 2.05008) (466230, 2.54679)} core_loss_type="Electrical Steel" core_loss_kh=163.158 core_loss_kc=0.865263 mass_density=7220
  vacuum: permittivity=1

design StatorAndRotor (Maxwell 2D, Magnetostatic, XY geometry, model units mm)
geometry:
  Key = rectangle(corner=(-3mm, 0mm, 0mm), x_size=6mm, y_size=18mm)
  Polyline1 = polyline(z=0mm, xy in mm: (-3, 18) (3, 18) (3, 18.3) (-3, 18), closed, covered)
  Key.unite(Polyline1)
  Rotor_Outer [DW315_50_2DSF0.950] = circle(normal=Z, centre=(0mm, 0mm, 0mm), radius=48mm)
  Circle2 = circle(normal=Z, centre=(0mm, 0mm, 0mm), radius=15mm)
  Rotor_Outer.subtract(Circle2, Key)
  Stator_Outer [DW315_50_2DSF0.950] = imported_body()
  Number [DW315_50_2DSF0.950] = rectangle(corner=(56.5mm, 80mm, 0mm), x_size=2mm, y_size=-3.5mm)
  Rectangle6 = rectangle(corner=(60.5mm, 80mm, 0mm), x_size=2mm, y_size=-3.5mm)
  Rectangle7 = rectangle(corner=(64.5mm, 80mm, 0mm), x_size=2mm, y_size=-3.5mm)
  Rectangle8 = rectangle(corner=(68.5mm, 80mm, 0mm), x_size=2mm, y_size=-3.5mm)
  Rectangle9 = rectangle(corner=(72.5mm, 80mm, 0mm), x_size=2mm, y_size=-3.5mm)
  Number.unite(Rectangle6..Rectangle9)
  Circle3 = circle(normal=Z, centre=(0mm, 0mm, 0mm), radius=15mm)
  Shaft [DW315_50_2DSF0.950] = polyline(z=0mm, xy in mm: (-3, 14.696938) (-3, 18) (3, 18.3) (3, 14.696938) (-3, 14.696938), closed, covered)
  Shaft.unite(Circle3)
mesh:
  initial mesh: MeshMethod=AnsoftTAU
